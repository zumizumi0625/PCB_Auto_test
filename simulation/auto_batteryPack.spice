* Auto-generated SPICE test for batteryPack
* Components: 48
* Power nets: +3V3=3.3V
* Detected: LDO Reset

.title Auto-Test: batteryPack

* === LDO Regulator Test #0 (4.3V → 3.3V) ===
Vin_ldo0 vin_ldo0 0 DC 4.3
Rldo_drop0 vin_ldo0 vout_ldo0 0.5
Cldo_out0 vout_ldo0 0 10u IC=3.3
Rldo_load0 vout_ldo0 0 33.0
* Switching load
Ildo_sw0 vout_ldo0 0 PULSE(0 50m 10u 100n 100n 1u 10u)

* === Reset Circuit Test #0 (detected: RST) ===
VCC_rst0 vcc_rst0 0 DC 3.3
Vtimer_rst0 timer_rst0 0 PULSE(3.3 0 5m 1u 1u 10m 100m)
Rdrv_rst0 timer_rst0 rst_filt0 100
Cfilt_rst0 rst_filt0 0 100n
Rout_rst0 rst_filt0 rst_out0 10
Cout_rst0 rst_out0 0 10n

* Divider: R8=62k / R9=10k
V_div0 div0_in 0 DC 3.3
R_div0_top div0_in div0_out 62000.0
R_div0_bot div0_out 0 10000.0

* Divider: R8=62k / R7=1k
V_div1 div1_in 0 DC 3.3
R_div1_top div1_in div1_out 62000.0
R_div1_bot div1_out 0 1000.0

* Divider: R9=10k / R10=10k
V_div2 div2_in 0 DC 3.3
R_div2_top div2_in div2_out 10000.0
R_div2_bot div2_out 0 10000.0

* Divider: R5=1k / R6=1k
V_div3 div3_in 0 DC 3.3
R_div3_top div3_in div3_out 1000.0
R_div3_bot div3_out 0 1000.0

* Divider: R5=1k / R4=2k4
V_div4 div4_in 0 DC 3.3
R_div4_top div4_in div4_out 1000.0
R_div4_bot div4_out 0 2400.0

.tran 10n 0.5 UIC
.op

.control
  run

  echo "========================================="
  echo "  Auto-Test: batteryPack"
  echo "  Detected: LDO, Reset"
  echo "========================================="

  echo "RESULT:components=48" > simulation_results.txt
  let pass = 1

  * --- LDO #0 (3.3V) ---
  let ldo0_avg = -1
  meas tran ldo0_avg avg v(vout_ldo0) from=5u to=9u
  let ldo0_min = -1
  meas tran ldo0_min min v(vout_ldo0) from=10u to=20u
  echo "LDO#0: avg=$&ldo0_avg V, min=$&ldo0_min V"
  echo "RESULT:ldo0_avg=$&ldo0_avg" >> simulation_results.txt
  if $&ldo0_avg < 3.135
    echo "FAIL: LDO#0 output too low"
    let pass = 0
  end
  if $&ldo0_avg > 3.465
    echo "FAIL: LDO#0 output too high"
    let pass = 0
  end

  * --- Reset Circuit #0 ---
  let rst0_t1 = -1
  let rst0_t2 = -1
  meas tran rst0_t1 when v(rst_out0)=1.65 fall=1
  meas tran rst0_t2 when v(rst_out0)=1.65 fall=2
  let rst0_period = -1
  if $&rst0_t1 > 0
    if $&rst0_t2 > 0
      let rst0_period = rst0_t2 - rst0_t1
    end
  end
  let rst0_min = -1
  meas tran rst0_min min v(rst_out0)
  echo "Reset#0: period=$&rst0_period s, Vmin=$&rst0_min V"
  echo "RESULT:rst0_period=$&rst0_period" >> simulation_results.txt
  if $&rst0_period > 0
    if $&rst0_period < 50m
      echo "FAIL: Reset#0 period too short"
      let pass = 0
    end
  end
  if $&rst0_min > 0.8
    echo "FAIL: Reset#0 does not pull low"
    let pass = 0
  end

  let v_div0 = v(div0_out)
  echo "Divider R8/R9: $&v_div0 V (exp 0.4583)"
  echo "RESULT:div_R8_R9=$&v_div0" >> simulation_results.txt
  if $&v_div0 < 0.4354
    let pass = 0
  end
  if $&v_div0 > 0.4813
    let pass = 0
  end

  let v_div1 = v(div1_out)
  echo "Divider R8/R7: $&v_div1 V (exp 0.0524)"
  echo "RESULT:div_R8_R7=$&v_div1" >> simulation_results.txt
  if $&v_div1 < 0.0498
    let pass = 0
  end
  if $&v_div1 > 0.055
    let pass = 0
  end

  let v_div2 = v(div2_out)
  echo "Divider R9/R10: $&v_div2 V (exp 1.6500)"
  echo "RESULT:div_R9_R10=$&v_div2" >> simulation_results.txt
  if $&v_div2 < 1.5675
    let pass = 0
  end
  if $&v_div2 > 1.7325
    let pass = 0
  end

  let v_div3 = v(div3_out)
  echo "Divider R5/R6: $&v_div3 V (exp 1.6500)"
  echo "RESULT:div_R5_R6=$&v_div3" >> simulation_results.txt
  if $&v_div3 < 1.5675
    let pass = 0
  end
  if $&v_div3 > 1.7325
    let pass = 0
  end

  let v_div4 = v(div4_out)
  echo "Divider R5/R4: $&v_div4 V (exp 2.3294)"
  echo "RESULT:div_R5_R4=$&v_div4" >> simulation_results.txt
  if $&v_div4 < 2.2129
    let pass = 0
  end
  if $&v_div4 > 2.4459
    let pass = 0
  end

  echo "Power estimate: 24.6mA / 81.1mW"
  echo "RESULT:est_current_mA=24.6" >> simulation_results.txt
  echo "RESULT:est_power_mW=81.1" >> simulation_results.txt

  if $&pass > 0
    echo "PASS: All auto-generated checks passed"
    echo "STATUS:PASS" >> simulation_results.txt
  else
    echo "STATUS:FAIL" >> simulation_results.txt
  end

  quit
.endc

.end
