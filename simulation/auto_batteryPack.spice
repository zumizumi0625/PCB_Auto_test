* Auto-generated SPICE test for batteryPack
* Components: 48
* Power nets: +3V3=3.3V
* Detected: LDO MOSFET-Prot Reset

.title Auto-Test: batteryPack

* === LDO Regulator Test #0 (4.3V → 3.3V) ===
* Ideal LDO model: regulated output with output impedance
Vldo0 vout_ldo0 0 DC 3.3
Rldo_out0 vout_ldo0 vout_ldo_load0 0.1
Cldo_out0 vout_ldo_load0 0 10u IC=3.3
Rldo_load0 vout_ldo_load0 0 33.0
* Switching load
Ildo_sw0 vout_ldo_load0 0 PULSE(0 50m 10u 100n 100n 1u 10u)

* === Reset Circuit Test #0 (detected: RST) ===
VCC_rst0 vcc_rst0 0 DC 3.3
Vtimer_rst0 timer_rst0 0 PULSE(3.3 0 5m 1u 1u 10m 100m)
Rdrv_rst0 timer_rst0 rst_filt0 100
Cfilt_rst0 rst_filt0 0 100n
Rout_rst0 rst_filt0 rst_out0 10
Cout_rst0 rst_out0 0 10n

* === Reverse Voltage Test #0 (3.3V rail) ===
* Simulates battery/connector reversed polarity
* Protected load should see minimal reverse voltage
Vin_rev0 vin_rev0 0 DC -3.3
* Series diode protection model (Schottky)
D_prot0 vin_rev0 vout_rev0 SCHOTTKY_PROT
Rload_rev0 vout_rev0 0 100

.model SCHOTTKY_PROT D (IS=1e-5 N=1.05 RS=0.1 BV=30 CJO=10p)

* === Overvoltage Surge Test #0 (3.3V rail, 13.2V surge) ===
Vin_surge0 vin_surge0 0 PULSE(3.3 13.2 10u 100n 100n 10u 50u)
* TVS clamp model
D_tvs_f0 vin_surge0 0 TVS_AUTO
D_tvs_r0 0 vin_surge0 TVS_AUTO
* Series protection + load
Rs_surge0 vin_surge0 vout_surge0 10
Cl_surge0 vout_surge0 0 10u IC=3.3
Rl_surge0 vout_surge0 0 50

.model TVS_AUTO D (BV=4.0 IBV=10m RS=0.5 CJO=200p)

* === Radiation SET Test #0 (3.3V rail) ===
Vreg_set0 vcc_set0 0 DC 3.3
Rout_set0 vcc_set0 vout_set0 0.5
Cout_set0 vout_set0 0 10u IC=3.3
Cdec_set0 vout_set0 0 100n IC=3.3
Rload_set0 vout_set0 0 110
* SET current pulse injection (3 intensities)
Iset0_1 0 vout_set0 PULSE(0 1m 5u 100p 1n 0 100u)
Iset0_2 0 vout_set0 PULSE(0 3m 10u 100p 1n 0 100u)
Iset0_3 0 vout_set0 PULSE(0 5m 15u 100p 1n 0 100u)

* Divider: R8=62k / R9=10k
V_div0 div0_in 0 DC 3.3
R_div0_top div0_in div0_out 62000.0
R_div0_bot div0_out 0 10000.0

* Divider: R8=62k / R7=1k
V_div1 div1_in 0 DC 3.3
R_div1_top div1_in div1_out 62000.0
R_div1_bot div1_out 0 1000.0

* Divider: R9=10k / R10=10k
V_div2 div2_in 0 DC 3.3
R_div2_top div2_in div2_out 10000.0
R_div2_bot div2_out 0 10000.0

* Divider: R5=1k / R6=1k
V_div3 div3_in 0 DC 3.3
R_div3_top div3_in div3_out 1000.0
R_div3_bot div3_out 0 1000.0

* Divider: R5=1k / R4=2k4
V_div4 div4_in 0 DC 3.3
R_div4_top div4_in div4_out 1000.0
R_div4_bot div4_out 0 2400.0

.tran 100u 0.3 UIC
.op

.control
  run

  echo "========================================="
  echo "  Auto-Test: batteryPack"
  echo "  Detected: LDO, Reset"
  echo "========================================="

  echo "RESULT:components=48" > simulation_results.txt
  let pass = 1

  * --- LDO #0 (3.3V) ---
  let ldo0_avg = -1
  meas tran ldo0_avg avg v(vout_ldo_load0) from=10m to=50m
  let ldo0_min = -1
  meas tran ldo0_min min v(vout_ldo_load0) from=10m to=100m
  echo "LDO#0: avg=$&ldo0_avg V, min=$&ldo0_min V"
  echo "RESULT:ldo0_avg=$&ldo0_avg" >> simulation_results.txt
  if $&ldo0_avg < 3.135
    echo "FAIL: LDO#0 output too low"
    let pass = 0
  end
  if $&ldo0_avg > 3.465
    echo "FAIL: LDO#0 output too high"
    let pass = 0
  end

  * --- Reset Circuit #0 ---
  let rst0_t1 = -1
  let rst0_t2 = -1
  meas tran rst0_t1 when v(rst_out0)=1.65 fall=1
  meas tran rst0_t2 when v(rst_out0)=1.65 fall=2
  let rst0_period = -1
  if $&rst0_t1 > 0
    if $&rst0_t2 > 0
      let rst0_period = rst0_t2 - rst0_t1
    end
  end
  let rst0_min = -1
  meas tran rst0_min min v(rst_out0)
  echo "Reset#0: period=$&rst0_period s, Vmin=$&rst0_min V"
  echo "RESULT:rst0_period=$&rst0_period" >> simulation_results.txt
  if $&rst0_period > 0
    if $&rst0_period < 50m
      echo "FAIL: Reset#0 period too short"
      let pass = 0
    end
  end
  if $&rst0_min > 0.8
    echo "FAIL: Reset#0 does not pull low"
    let pass = 0
  end

  * --- Reverse Voltage #0 ---
  let vrev0 = v(vout_rev0)
  echo "Reverse#0: output=$&vrev0 V (should be near 0)"
  echo "RESULT:reverse0_vout=$&vrev0" >> simulation_results.txt
  * Protected output must stay above -0.33V
  if $&vrev0 < -0.33
    echo "FAIL: Reverse voltage not blocked (3.3V rail)"
    let pass = 0
  end

  * --- Overvoltage Surge #0 ---
  let vsurge0_normal = -1
  meas tran vsurge0_normal avg v(vout_surge0) from=1u to=9u
  let vsurge0_peak = -1
  meas tran vsurge0_peak max v(vout_surge0) from=10u to=25u
  let vsurge0_recovery = -1
  meas tran vsurge0_recovery avg v(vout_surge0) from=35u to=45u
  echo "Surge#0: normal=$&vsurge0_normal V, peak=$&vsurge0_peak V, recovery=$&vsurge0_recovery V"
  echo "RESULT:surge0_normal=$&vsurge0_normal" >> simulation_results.txt
  echo "RESULT:surge0_peak=$&vsurge0_peak" >> simulation_results.txt
  echo "RESULT:surge0_recovery=$&vsurge0_recovery" >> simulation_results.txt
  * Peak must stay below 4.9V (1.5x nominal)
  if $&vsurge0_peak > 4.9
    echo "FAIL: Surge#0 not clamped (peak=$&vsurge0_peak V > 4.9V)"
    let pass = 0
  end
  * Must recover after surge
  if $&vsurge0_recovery < 2.97
    echo "FAIL: Surge#0 did not recover"
    let pass = 0
  end

  * --- Radiation SET #0 (3.3V) ---
  let set0_nominal = -1
  meas tran set0_nominal avg v(vout_set0) from=1u to=4u
  let set0_peak = -1
  meas tran set0_peak max v(vout_set0) from=5u to=20u
  echo "SET#0: nominal=$&set0_nominal V, peak=$&set0_peak V"
  echo "RESULT:set0_nominal=$&set0_nominal" >> simulation_results.txt
  echo "RESULT:set0_peak=$&set0_peak" >> simulation_results.txt
  * Peak must stay below absolute max (3.63V)
  if $&set0_peak > 3.63
    echo "FAIL: SET#0 exceeds abs max (3.63V)"
    let pass = 0
  end

  let v_div0 = v(div0_out)
  echo "Divider R8/R9: $&v_div0 V (exp 0.4583)"
  echo "RESULT:div_R8_R9=$&v_div0" >> simulation_results.txt
  if $&v_div0 < 0.4354
    let pass = 0
  end
  if $&v_div0 > 0.4813
    let pass = 0
  end

  let v_div1 = v(div1_out)
  echo "Divider R8/R7: $&v_div1 V (exp 0.0524)"
  echo "RESULT:div_R8_R7=$&v_div1" >> simulation_results.txt
  if $&v_div1 < 0.0498
    let pass = 0
  end
  if $&v_div1 > 0.055
    let pass = 0
  end

  let v_div2 = v(div2_out)
  echo "Divider R9/R10: $&v_div2 V (exp 1.6500)"
  echo "RESULT:div_R9_R10=$&v_div2" >> simulation_results.txt
  if $&v_div2 < 1.5675
    let pass = 0
  end
  if $&v_div2 > 1.7325
    let pass = 0
  end

  let v_div3 = v(div3_out)
  echo "Divider R5/R6: $&v_div3 V (exp 1.6500)"
  echo "RESULT:div_R5_R6=$&v_div3" >> simulation_results.txt
  if $&v_div3 < 1.5675
    let pass = 0
  end
  if $&v_div3 > 1.7325
    let pass = 0
  end

  let v_div4 = v(div4_out)
  echo "Divider R5/R4: $&v_div4 V (exp 2.3294)"
  echo "RESULT:div_R5_R4=$&v_div4" >> simulation_results.txt
  if $&v_div4 < 2.2129
    let pass = 0
  end
  if $&v_div4 > 2.4459
    let pass = 0
  end

  echo "Power estimate: 24.6mA / 81.1mW"
  echo "RESULT:est_current_mA=24.6" >> simulation_results.txt
  echo "RESULT:est_power_mW=81.1" >> simulation_results.txt

  if $&pass > 0
    echo "PASS: All auto-generated checks passed"
    echo "STATUS:PASS" >> simulation_results.txt
  else
    echo "STATUS:FAIL" >> simulation_results.txt
  end

  quit
.endc

.end
