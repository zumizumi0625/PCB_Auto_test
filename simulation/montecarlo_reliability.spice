* Worst-Case Component Tolerance Analysis
*
* Voltage divider: Vout = Vin * R2/(R1+R2)
* With 5% tolerance, check output stays within spec

.title Component Tolerance Analysis

* Worst case LOW: R1=max(10.5k), R2=min(9.5k)
* Vout = 5 * 9.5k / (10.5k + 9.5k) = 2.375V

V1 in 0 DC 5
R1 in out 10.5k
R2 out 0 9.5k

.control
  op
  let vout_low = v(out)
  echo "Worst case LOW Vout:" $&vout_low "V"

  * Worst case HIGH: R1=min(9.5k), R2=max(10.5k)
  * Vout = 5 * 10.5k / (9.5k + 10.5k) = 2.625V
  alter R1 = 9.5k
  alter R2 = 10.5k
  op
  let vout_high = v(out)
  echo "Worst case HIGH Vout:" $&vout_high "V"

  echo "=== Tolerance Analysis (5% resistors) ==="
  echo "Low:" $&vout_low "V"
  echo "High:" $&vout_high "V"

  echo "RESULT:vout_low=$&vout_low" > simulation_results.txt
  echo "RESULT:vout_high=$&vout_high" >> simulation_results.txt

  * Both must be within 2.25V - 2.75V (±10% of 2.5V)
  let pass = 1
  if vout_low < 2.25
    let pass = 0
  end
  if vout_high > 2.75
    let pass = 0
  end

  if pass
    echo "PASS: Output within tolerance"
    echo "STATUS:PASS" >> simulation_results.txt
  else
    echo "FAIL: Output exceeds tolerance"
    echo "STATUS:FAIL" >> simulation_results.txt
  end

  quit
.endc

.end
