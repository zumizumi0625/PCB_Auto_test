* Monte Carlo Reliability Analysis
* Tests voltage divider with component tolerance
*
* Nominal: Vout = 5 * 10k/(10k+10k) = 2.5V
* With 5% tolerance, output should stay within 10% of nominal

.title Monte Carlo - Component Tolerance

V1 in 0 DC 5
R1 in out 10k
R2 out 0 10k

.control
  * Nominal case
  op
  let v_nom = v(out)
  echo "Nominal Vout:" $&v_nom "V"

  * Worst case: R1 max, R2 min → lowest Vout
  alter R1 = 10.5k
  alter R2 = 9.5k
  op
  let v_worst_low = v(out)

  * Worst case: R1 min, R2 max → highest Vout
  alter R1 = 9.5k
  alter R2 = 10.5k
  op
  let v_worst_high = v(out)

  * Reset
  alter R1 = 10k
  alter R2 = 10k

  let spread = v_worst_high - v_worst_low

  echo "=== Tolerance Analysis (5% resistors) ==="
  echo "Worst case low:" $&v_worst_low "V"
  echo "Worst case high:" $&v_worst_high "V"
  echo "Spread:" $&spread "V"

  echo "RESULT:v_nominal=$&v_nom" > simulation_results.txt
  echo "RESULT:v_worst_low=$&v_worst_low" >> simulation_results.txt
  echo "RESULT:v_worst_high=$&v_worst_high" >> simulation_results.txt
  echo "RESULT:spread=$&spread" >> simulation_results.txt

  let pass = 1
  * Output must stay within 10% of 2.5V (2.25V to 2.75V)
  if v_worst_low < 2.25
    let pass = 0
  end
  if v_worst_high > 2.75
    let pass = 0
  end

  if pass
    echo "PASS: Output within tolerance across component variations"
    echo "STATUS:PASS" >> simulation_results.txt
  else
    echo "FAIL: Output exceeds tolerance"
    echo "STATUS:FAIL" >> simulation_results.txt
  end

  quit
.endc

.end
