* I2C Bus Integrity Simulation
* Tests pull-up resistor sizing and signal integrity
*
* Checks:
* 1. Rise time meets I2C spec (< 1us for standard mode)
* 2. VOL is below 0.4V threshold

.title I2C Bus Integrity Check

VCC vcc 0 DC 3.3

* Pull-up resistors (4.7k typical)
Rp_sda vcc sda 4.7k
Rp_scl vcc scl 4.7k

* Bus capacitance (200pF — multiple devices + traces)
Cbus_sda sda 0 200p
Cbus_scl scl 0 200p

* Open-drain driver (NMOS)
M1 sda gate_sda 0 0 NMOS W=50u L=0.5u
Vgate_sda gate_sda 0 PULSE(3.3 0 0 10n 10n 5u 10u)

M2 scl gate_scl 0 0 NMOS W=50u L=0.5u
Vgate_scl gate_scl 0 PULSE(3.3 0 1u 10n 10n 4u 10u)

.model NMOS NMOS (VTO=0.7 KP=110u GAMMA=0.4 LAMBDA=0.04 CBD=5p CBS=5p)

.tran 10n 50u

.control
  run

  meas tran t_sda_10 when v(sda)=0.33 rise=1
  meas tran t_sda_90 when v(sda)=2.97 rise=1
  let rise_time_sda = t_sda_90 - t_sda_10

  meas tran vol_sda min v(sda) from=0 to=4u

  echo "=== I2C Bus Integrity Results ==="
  echo "SDA Rise Time:" $&rise_time_sda "s"
  echo "SDA VOL:" $&vol_sda "V"

  echo "RESULT:rise_time_sda=$&rise_time_sda" > simulation_results.txt
  echo "RESULT:vol_sda=$&vol_sda" >> simulation_results.txt

  * Check rise time < 1us
  let pass = 1
  if rise_time_sda > 1e-6
    let pass = 0
  end
  * Check VOL < 0.4V
  if vol_sda > 0.4
    let pass = 0
  end

  if pass
    echo "PASS: I2C bus meets Standard Mode specifications"
    echo "STATUS:PASS" >> simulation_results.txt
  else
    echo "FAIL: I2C bus does not meet specifications"
    echo "STATUS:FAIL" >> simulation_results.txt
  end

  quit
.endc

.end
