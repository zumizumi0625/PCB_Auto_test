* SPI Signal Integrity — Clock Signal Quality Check
*
* Tests SCLK through a simplified trace model
* Checks that signal reaches proper logic levels

.title SPI Signal Integrity

* SCLK source — 1MHz
Vsclk sclk_src 0 PULSE(0 3.3 0 5n 5n 500n 1u)

* Driver output impedance
Rdrv sclk_src sclk_a 33

* Trace model (lumped LC)
Ltrace sclk_a sclk_b 10n
Rtrace sclk_b sclk 10

* Load (slave device input capacitance)
Cload sclk 0 15p

.tran 1n 3u

.control
  run

  meas tran vmax max v(sclk)
  meas tran vmin min v(sclk)

  echo "=== SPI Signal Results ==="
  echo "SCLK max:" $&vmax "V"
  echo "SCLK min:" $&vmin "V"

  echo "RESULT:sclk_max=$&vmax" > simulation_results.txt
  echo "RESULT:sclk_min=$&vmin" >> simulation_results.txt

  * Check signal reaches valid levels
  let pass = 1
  if vmax < 2.5
    let pass = 0
  end
  if vmin > 0.5
    let pass = 0
  end

  if pass
    echo "PASS: SPI signal quality OK"
    echo "STATUS:PASS" >> simulation_results.txt
  else
    echo "FAIL: SPI signal quality issue"
    echo "STATUS:FAIL" >> simulation_results.txt
  end

  quit
.endc

.end
