* SPI Signal Integrity Simulation
* Tests clock and data line quality at 1MHz

.title SPI Signal Integrity Check

VCC vcc 0 DC 3.3

* SCLK — 1MHz with trace model
Vsclk_drv sclk_drv 0 PULSE(0 3.3 0 5n 5n 500n 1u)
Rdrv_sclk sclk_drv sclk_near 33
Ltrace_sclk sclk_near sclk_mid 10n
Ctrace_sclk sclk_mid 0 5p
Rtrace_sclk sclk_mid sclk 10
Cload_sclk sclk 0 15p

* MOSI — data with setup time
Vmosi_drv mosi_drv 0 PULSE(0 3.3 50n 5n 5n 450n 1u)
Rdrv_mosi mosi_drv mosi_near 33
Ltrace_mosi mosi_near mosi_mid 10n
Ctrace_mosi mosi_mid 0 5p
Rtrace_mosi mosi_mid mosi 10
Cload_mosi mosi 0 15p

.tran 1n 5u

.control
  run

  meas tran sclk_rise trig v(sclk)=0.33 rise=1 targ v(sclk)=2.97 rise=1
  meas tran sclk_max max v(sclk)
  meas tran sclk_min min v(sclk) from=0.5u to=1u

  meas tran t_mosi_stable when v(mosi)=1.65 rise=1
  meas tran t_sclk_rise when v(sclk)=1.65 rise=1
  let setup_time = t_sclk_rise - t_mosi_stable

  echo "=== SPI Signal Integrity Results ==="
  echo "SCLK Rise Time:" $&sclk_rise "s"
  echo "SCLK Max:" $&sclk_max "V"
  echo "SCLK Min:" $&sclk_min "V"
  echo "Setup Time:" $&setup_time "s"

  echo "RESULT:sclk_rise=$&sclk_rise" > simulation_results.txt
  echo "RESULT:sclk_max=$&sclk_max" >> simulation_results.txt
  echo "RESULT:setup_time=$&setup_time" >> simulation_results.txt

  let pass = 1
  if sclk_max > 3.63
    let pass = 0
  end
  if sclk_min < -0.3
    let pass = 0
  end
  if setup_time < 10n
    let pass = 0
  end

  if pass
    echo "PASS: SPI signals meet integrity requirements"
    echo "STATUS:PASS" >> simulation_results.txt
  else
    echo "FAIL: SPI signal integrity issues detected"
    echo "STATUS:FAIL" >> simulation_results.txt
  end

  quit
.endc

.end
