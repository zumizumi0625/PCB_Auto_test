* RC Low-Pass Filter — Example SPICE Simulation
* Tests basic circuit simulation in CI pipeline
*
* Circuit: Vin → R1(1k) → node(out) → C1(100nF) → GND
* Expected: -3dB cutoff at ~1.59kHz

.title RC Low-Pass Filter

* Power supply (AC source)
V1 in 0 AC 1

* Components
R1 in out 1k
C1 out 0 100n

* AC analysis: 100 points per decade, 1Hz to 1MHz
.ac dec 100 1 1meg

.control
  run

  * Expected cutoff frequency: f = 1/(2*pi*R*C)
  let cutoff_freq = 1/(2*PI*1k*100n)
  echo "Expected cutoff frequency:" $&cutoff_freq "Hz"

  * Find the -3dB point by checking gain
  let gain_db = vdb(out)
  let target = -3

  * Manual search: find frequency where gain crosses -3dB
  let idx = 0
  let f3db_found = 0
  while idx < length(gain_db) - 1
    if gain_db[idx] >= target and gain_db[idx+1] < target
      let f3db_found = frequency[idx]
      break
    end
    let idx = idx + 1
  end

  echo "Measured -3dB frequency:" $&f3db_found "Hz"

  * Check if within 10% tolerance
  let error_pct = abs(f3db_found - cutoff_freq)/cutoff_freq * 100
  echo "Error:" $&error_pct "%"

  * Write results
  echo "RESULT:cutoff_freq=$&cutoff_freq" > simulation_results.txt
  echo "RESULT:f3db=$&f3db_found" >> simulation_results.txt
  echo "RESULT:error_pct=$&error_pct" >> simulation_results.txt

  if error_pct > 10
    echo "FAIL: Cutoff frequency error exceeds 10%"
    echo "STATUS:FAIL" >> simulation_results.txt
  else
    echo "PASS: Cutoff frequency within tolerance"
    echo "STATUS:PASS" >> simulation_results.txt
  end

  quit
.endc

.end
