* Periodic Hardware Reset Circuit — Timer + RC Pulse Shaper
*
* Models a hardware watchdog timer for satellite applications:
* - Timer generates periodic trigger (modeled as voltage pulse source)
* - RC network shapes the reset pulse width
* - Open-drain output with pull-up for reset line
*
* Verifies:
* 1. Reset pulse period matches design target
* 2. Reset pulse width sufficient for MCU reset (>1ms typical)
* 3. Reset line returns to valid HIGH between pulses
* 4. Rise/fall times appropriate for reset input
*
* Design: 10s period, 10ms reset pulse width
* Timer IC output modeled as ideal pulse (behavioral)

.title Periodic Reset Circuit

VCC vcc 0 DC 3.3

* =============================================
* Timer Output (behavioral model of 555/watchdog IC)
* Period: 10s, narrow trigger pulse: 100us
* =============================================
V_timer timer_out 0 PULSE(0 3.3 0 1u 1u 100u 100m)

* =============================================
* Reset Pulse Shaper
* =============================================
* RC monostable: converts trigger edge into controlled-width pulse
* Pulse width ≈ 0.7 * R * C = 0.7 * 100k * 100nF = 7ms

* Coupling capacitor (differentiator)
C_couple timer_out coupled 100n

* Discharge path
R_discharge coupled 0 100k

* NMOS pulls reset line low when coupled goes positive
M_rst rst_raw coupled 0 0 NMOD W=200u L=0.5u
.model NMOD NMOS (VTO=0.7 KP=200u)

* Reset line with pull-up (active-low)
R_pullup vcc rst_raw 10k

* Output filter for clean edges
R_filt rst_raw rst_out 100
C_filt rst_out 0 1n

.tran 10u 0.5

.control
  run

  * === Period Measurement ===
  * Measure time between successive reset assertions
  let t_rst1 = -1
  let t_rst2 = -1
  meas tran t_rst1 when v(rst_out)=1.65 fall=1
  meas tran t_rst2 when v(rst_out)=1.65 fall=2

  let period = -1
  if $&t_rst1 > 0
    if $&t_rst2 > 0
      let period = t_rst2 - t_rst1
    end
  end

  * === Reset Pulse Width ===
  * Time that reset is asserted (below 0.8V = VIL for 3.3V CMOS)
  let t_fall = -1
  let t_rise = -1
  meas tran t_fall when v(rst_out)=0.8 fall=1
  meas tran t_rise when v(rst_out)=0.8 rise=1

  let pulse_width = -1
  if $&t_fall > 0
    if $&t_rise > 0
      let pulse_width = t_rise - t_fall
    end
  end

  * === Voltage Levels ===
  let v_high = -1
  let v_low = -1
  meas tran v_high avg v(rst_out) from=50m to=90m
  meas tran v_low min v(rst_out)

  * === Report ===
  echo "========================================="
  echo "  Periodic Reset Circuit Report"
  echo "========================================="
  echo "Timer period:     $&period s"
  echo "Reset pulse width: $&pulse_width s"
  echo "Reset HIGH level: $&v_high V"
  echo "Reset LOW level:  $&v_low V"

  echo "RESULT:period=$&period" > simulation_results.txt
  echo "RESULT:pulse_width=$&pulse_width" >> simulation_results.txt
  echo "RESULT:v_high=$&v_high" >> simulation_results.txt
  echo "RESULT:v_low=$&v_low" >> simulation_results.txt

  * === Spec Checks ===
  let pass = 1

  * Check 1: Period matches timer setting (100ms ± 20%)
  if $&period > 0
    if $&period < 80m
      echo "FAIL: Period too short ($&period s)"
      let pass = 0
    end
    if $&period > 120m
      echo "FAIL: Period too long ($&period s)"
      let pass = 0
    end
  else
    echo "FAIL: Could not measure period"
    let pass = 0
  end

  * Check 2: Reset pulse width > 1ms (MCU minimum reset time)
  if $&pulse_width > 0
    if $&pulse_width < 1m
      echo "FAIL: Reset pulse too narrow ($&pulse_width s)"
      let pass = 0
    end
  else
    echo "FAIL: Could not measure pulse width"
    let pass = 0
  end

  * Check 3: HIGH level is valid logic high (> VIH = 2.0V)
  if $&v_high < 2.0
    echo "FAIL: Reset HIGH too low ($&v_high V)"
    let pass = 0
  end

  * Check 4: LOW level pulls below VIL (< 0.8V)
  if $&v_low > 0.8
    echo "FAIL: Reset LOW not low enough ($&v_low V)"
    let pass = 0
  end

  if $&pass > 0
    echo "PASS: Periodic reset circuit operating correctly"
    echo "STATUS:PASS" >> simulation_results.txt
  else
    echo "STATUS:FAIL" >> simulation_results.txt
  end

  quit
.endc

.end
