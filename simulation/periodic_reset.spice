* Periodic Hardware Reset Circuit
*
* Models a hardware watchdog timer output driving an MCU reset line.
* Timer IC outputs active-LOW pulse periodically.
* RC filter ensures clean edges on the reset line.
*
* In satellite applications, this provides automatic recovery
* from radiation-induced MCU lockups.
*
* Design: 100ms period (scaled from real 10s for CI speed), 10ms reset pulse

.title Periodic Reset Circuit

VCC vcc 0 DC 3.3

* =============================================
* Timer Output (behavioral model of watchdog IC)
* Outputs LOW pulse of 10ms every 100ms
* =============================================
V_timer timer_out 0 PULSE(3.3 0 5m 1u 1u 10m 100m)

* =============================================
* Reset line driver with RC filtering
* =============================================
R_drive timer_out rst_filt 100
C_filt rst_filt 0 100n

* Output buffer
R_out rst_filt rst_out 10
C_out rst_out 0 10n

.tran 10u 0.5

.control
  run

  * === Period Measurement ===
  let t_rst1 = -1
  let t_rst2 = -1
  meas tran t_rst1 when v(rst_out)=1.65 fall=1
  meas tran t_rst2 when v(rst_out)=1.65 fall=2

  let period = -1
  if $&t_rst1 > 0
    if $&t_rst2 > 0
      let period = t_rst2 - t_rst1
    end
  end

  * === Reset Pulse Width ===
  let t_fall = -1
  let t_rise = -1
  meas tran t_fall when v(rst_out)=0.8 fall=1
  meas tran t_rise when v(rst_out)=0.8 rise=1

  let pulse_width = -1
  if $&t_fall > 0
    if $&t_rise > $&t_fall
      let pulse_width = t_rise - t_fall
    end
  end

  * === Voltage Levels ===
  let v_high = -1
  let v_low = -1
  meas tran v_high avg v(rst_out) from=50m to=90m
  meas tran v_low min v(rst_out)

  * === Report ===
  echo "========================================="
  echo "  Periodic Reset Circuit Report"
  echo "========================================="
  echo "Timer period:      $&period s"
  echo "Reset pulse width: $&pulse_width s"
  echo "Reset HIGH level:  $&v_high V"
  echo "Reset LOW level:   $&v_low V"

  echo "RESULT:period=$&period" > simulation_results.txt
  echo "RESULT:pulse_width=$&pulse_width" >> simulation_results.txt
  echo "RESULT:v_high=$&v_high" >> simulation_results.txt
  echo "RESULT:v_low=$&v_low" >> simulation_results.txt

  * === Spec Checks ===
  let pass = 1

  * Check 1: Period matches design (100ms ± 20%)
  if $&period > 0
    if $&period < 80m
      echo "FAIL: Period too short ($&period s)"
      let pass = 0
    end
    if $&period > 120m
      echo "FAIL: Period too long ($&period s)"
      let pass = 0
    end
  else
    echo "FAIL: Could not measure period"
    let pass = 0
  end

  * Check 2: Reset pulse > 1ms (MCU minimum reset time)
  if $&pulse_width > 0
    if $&pulse_width < 1m
      echo "FAIL: Reset pulse too narrow ($&pulse_width s)"
      let pass = 0
    end
  else
    echo "FAIL: Could not measure pulse width"
    let pass = 0
  end

  * Check 3: HIGH level valid (> VIH = 2.0V)
  if $&v_high < 2.0
    echo "FAIL: Reset HIGH too low ($&v_high V)"
    let pass = 0
  end

  * Check 4: LOW level valid (< VIL = 0.8V)
  if $&v_low > 0.8
    echo "FAIL: Reset LOW too high ($&v_low V)"
    let pass = 0
  end

  if $&pass > 0
    echo "PASS: Periodic reset circuit operating correctly"
    echo "STATUS:PASS" >> simulation_results.txt
  else
    echo "STATUS:FAIL" >> simulation_results.txt
  end

  quit
.endc

.end
