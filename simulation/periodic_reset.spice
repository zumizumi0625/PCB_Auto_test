* Periodic Hardware Reset Circuit (RC Oscillator Watchdog)
*
* Uses a relaxation oscillator (Schmitt trigger + RC)
* to generate periodic reset pulses.
*
* In satellite applications, this provides automatic recovery
* from radiation-induced MCU lockups.
*
* Circuit: RC relaxation oscillator
* - Period ≈ 2 * R * C * ln(3) ≈ 2.2 * R * C
* - Using 100k + 1uF → period ≈ 220ms
* - Output: periodic pulse (reset assertion)

.title Periodic Reset Circuit

VCC vcc 0 DC 3.3

* =============================================
* Relaxation Oscillator
* =============================================
* RC timing
R_timing vcc cap_node 100k
C_timing cap_node 0 1u IC=0

* Discharge path: NMOS switch controlled by feedback
* When cap charges above threshold, NMOS turns on and discharges
M_discharge cap_node fb_node 0 0 NMOD W=50u L=0.5u
.model NMOD NMOS (VTO=0.7 KP=200u)

* Feedback: Schmitt trigger using inverter chain
* Stage 1: First inverter
Mp1 inv1_out cap_node vcc vcc PMOD W=5u L=0.5u
Mn1 inv1_out cap_node 0 0 NMOD W=5u L=0.5u

* Stage 2: Second inverter (restores phase)
Mp2 fb_node inv1_out vcc vcc PMOD W=5u L=0.5u
Mn2 fb_node inv1_out 0 0 NMOD W=5u L=0.5u

.model PMOD PMOS (VTO=-0.7 KP=50u)

* Hysteresis capacitor
C_hyst fb_node 0 100p

* =============================================
* Reset Output (buffered)
* =============================================
* Output buffer (inverter — active-low reset)
Mp3 rst_out inv1_out vcc vcc PMOD W=10u L=0.5u
Mn3 rst_out inv1_out 0 0 NMOD W=10u L=0.5u

.tran 1u 2m UIC

.control
  run

  * === Period Measurement ===
  * Measure time between rising edges on cap_node
  let t1 = -1
  let t2 = -1
  meas tran t1 when v(cap_node)=1.65 rise=1
  meas tran t2 when v(cap_node)=1.65 rise=2

  let period = -1
  if $&t1 > 0
    if $&t2 > 0
      let period = t2 - t1
    end
  end

  * === Reset Output ===
  let rst_min = -1
  let rst_max = -1
  meas tran rst_min min v(rst_out)
  meas tran rst_max max v(rst_out)

  * === Report ===
  echo "========================================="
  echo "  Periodic Reset Circuit Report"
  echo "========================================="
  echo "Timing: R=100k, C=1uF"
  echo ""
  echo "Oscillation period: $&period s"
  echo "Reset output min:   $&rst_min V"
  echo "Reset output max:   $&rst_max V"

  echo "RESULT:period=$&period" > simulation_results.txt
  echo "RESULT:rst_min=$&rst_min" >> simulation_results.txt
  echo "RESULT:rst_max=$&rst_max" >> simulation_results.txt

  * === Spec Checks ===
  let pass = 1

  * Check 1: Oscillation detected
  if $&period < 0
    echo "FAIL: No oscillation detected"
    let pass = 0
  end

  * Check 2: Period in expected range (50us - 5ms for these components)
  if $&period > 0
    if $&period > 5e-3
      echo "FAIL: Period too long ($&period s)"
      let pass = 0
    end
  end

  * Check 3: Reset output swings rail-to-rail
  if $&rst_max < 2.5
    echo "FAIL: Reset output does not reach high ($&rst_max V)"
    let pass = 0
  end

  if $&pass > 0
    echo "PASS: Periodic reset circuit operating correctly"
    echo "STATUS:PASS" >> simulation_results.txt
  else
    echo "STATUS:FAIL" >> simulation_results.txt
  end

  quit
.endc

.end
