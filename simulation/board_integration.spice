* Multi-Board Integration Test
*
* Simulates two PCBs connected via power cable + signal interface:
* [Board A: Power Supply] ──cable──> [Board B: Sensor Board]
*
* Tests:
* 1. Power voltage at Board B after cable/connector voltage drop
* 2. Voltage droop from switching loads
* 3. I2C signal integrity across board connector

.title Multi-Board Integration Test

* =============================================
* Board A: 5V Regulated Power Supply
* =============================================
V_reg reg_out 0 DC 5
R_reg reg_out pwr_a 0.1
C_a_decoup pwr_a 0 100u IC=5

* =============================================
* Power Cable + Connector (30cm 22AWG)
* =============================================
* Cable resistance (33mΩ/m × 0.3m) + connector contact
R_cable pwr_a pwr_cable 30m
L_cable pwr_cable pwr_b 50n

* =============================================
* Board B: Sensor Board
* =============================================
C_b_decoup pwr_b 0 10u IC=0

* Steady-state load: 50mA
R_load pwr_b 0 100

* Switching load: 10mA pulses at 1kHz
I_switch pwr_b 0 PULSE(0 10m 10u 100n 100n 1u 1m)

* =============================================
* I2C Signal Line
* =============================================
* Pull-up on Board A
R_pullup pwr_a sda_a 2.2k

* Master open-drain driver
M_sda sda_a gate_sda 0 0 NMOD W=100u L=0.5u
Vgate gate_sda 0 PULSE(3.3 0 5u 10n 10n 5u 10u)
.model NMOD NMOS (VTO=0.7 KP=200u GAMMA=0.4 LAMBDA=0.04)

* Connector + trace for signal
R_conn_sda sda_a sda_b 5
C_bus_b sda_b 0 100p

.tran 10n 25u UIC

.control
  run

  * === Power Bus Tests ===
  let v_b_pwr = -1
  meas tran v_b_pwr avg v(pwr_b) from=8u to=9u

  let v_b_min = -1
  meas tran v_b_min min v(pwr_b) from=10u to=15u

  * === Signal Tests ===
  let sda_vol = -1
  meas tran sda_vol avg v(sda_b) from=1u to=4u

  let sda_voh = -1
  meas tran sda_voh avg v(sda_b) from=8u to=9u

  * === Report ===
  echo "========================================="
  echo "  Multi-Board Integration Report"
  echo "========================================="
  echo "Board B Vcc (steady):    $&v_b_pwr V"
  echo "Board B Vcc (min droop): $&v_b_min V"
  echo "I2C SDA VOL at Board B:  $&sda_vol V"
  echo "I2C SDA VOH at Board B:  $&sda_voh V"

  echo "RESULT:board_b_vcc=$&v_b_pwr" > simulation_results.txt
  echo "RESULT:board_b_vcc_min=$&v_b_min" >> simulation_results.txt
  echo "RESULT:sda_vol=$&sda_vol" >> simulation_results.txt
  echo "RESULT:sda_voh=$&sda_voh" >> simulation_results.txt

  let pass = 1

  * Board B supply within 5% of 5V
  if $&v_b_pwr < 4.75
    echo "FAIL: Board B supply too low ($&v_b_pwr V)"
    let pass = 0
  end

  * Voltage droop < 10%
  if $&v_b_min < 4.5
    echo "FAIL: Excessive voltage droop ($&v_b_min V)"
    let pass = 0
  end

  * I2C VOL < 0.4V
  if $&sda_vol > 0.4
    echo "FAIL: I2C VOL too high ($&sda_vol V)"
    let pass = 0
  end

  * I2C VOH > 2.3V (VIH for 3.3V logic)
  if $&sda_voh < 2.3
    echo "FAIL: I2C VOH too low ($&sda_voh V)"
    let pass = 0
  end

  if $&pass > 0
    echo "PASS: Multi-board integration meets specifications"
    echo "STATUS:PASS" >> simulation_results.txt
  else
    echo "STATUS:FAIL" >> simulation_results.txt
  end

  quit
.endc

.end
