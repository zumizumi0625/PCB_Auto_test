* Overvoltage / Reverse Polarity Protection Simulation
*
* Checks:
* 1. TVS clamps voltage during surge
* 2. Normal operation passes voltage

.title Fault Protection - Overvoltage

* Normal 5V supply with TVS protection
Vin vin 0 PULSE(5 24 10u 100n 100n 10u 50u)

* TVS diode (5.6V rated)
D_tvs1 vin 0 TVS5V6
D_tvs2 0 vin TVS5V6
.model TVS5V6 D (BV=5.6 IBV=1 RS=0.5 CJO=200p)

* Series protection resistor + load
R_series vin vout 10
Rload vout 0 100

.tran 0.1u 80u

.control
  run

  meas tran v_normal avg v(vout) from=0 to=9u
  meas tran v_surge_max max v(vout) from=10u to=25u

  echo "=== Fault Protection Results ==="
  echo "Normal Vout (avg):" $&v_normal "V"
  echo "Surge Vout (max):" $&v_surge_max "V"

  echo "RESULT:v_normal=$&v_normal" > simulation_results.txt
  echo "RESULT:v_surge_max=$&v_surge_max" >> simulation_results.txt

  let pass = 1
  * Normal output should be close to 5V (considering divider: 100/(100+10)*5 = 4.55V)
  if v_normal < 4.0
    let pass = 0
  end
  * Surge should be clamped below 8V
  if v_surge_max > 8.0
    let pass = 0
  end

  if pass
    echo "PASS: Fault protection working correctly"
    echo "STATUS:PASS" >> simulation_results.txt
  else
    echo "FAIL: Fault protection issue detected"
    echo "STATUS:FAIL" >> simulation_results.txt
  end

  quit
.endc

.end
