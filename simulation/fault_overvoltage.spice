* Overvoltage / Reverse Polarity Protection Simulation
* Tests TVS diode + polarity protection MOSFET behavior
*
* Checks:
* 1. TVS clamps voltage below safe level during surge
* 2. Reverse polarity blocks current
* 3. Normal operation passes voltage with minimal drop

.title Fault Protection - Overvoltage & Reverse Polarity

* === Normal Operation Test ===
* 5V input through P-MOSFET reverse polarity protection
Vin_normal vin_n 0 DC 5

* P-MOSFET reverse polarity protection
* Gate tied to GND, Source to VIN → conducts when VIN > 0
M_prot 0 0 vin_n vout_n PMOS W=1000u L=0.5u
.model PMOS PMOS (VTO=-1.0 KP=40u)

* Load
Rload_n vout_n 0 100

* === Overvoltage Test ===
* 24V surge through TVS diode (5.6V rated)
Vin_surge vin_s 0 PULSE(5 24 1u 100n 100n 10u 50u)

* TVS diode model (simplified as back-to-back zener)
D_tvs1 vin_s 0 TVS5V6
D_tvs2 0 vin_s TVS5V6
.model TVS5V6 D (BV=5.6 IBV=1 RS=0.5 CJO=200p)

* Series resistor (current limiting)
R_series vin_s vout_s 10
* Load
Rload_s vout_s 0 100

* === Reverse Polarity Test ===
* -5V applied (reverse battery)
Vin_rev vin_r 0 DC -5

* P-MOSFET should block reverse current
M_rev 0 0 vin_r vout_r PMOS W=1000u L=0.5u

Rload_r vout_r 0 100

.tran 0.1u 60u
.op

.control
  * DC operating point first
  op

  let v_normal = v(vout_n)
  let v_reverse = v(vout_r)

  echo "=== Fault Protection Results ==="
  echo "Normal operation output:" $&v_normal "V"
  echo "Reverse polarity output:" $&v_reverse "V"

  * Transient for surge test
  tran 0.1u 60u
  meas tran v_surge_max max v(vout_s)
  meas tran v_surge_clamp max v(vin_s)

  echo "Surge: Max output voltage:" $&v_surge_max "V"
  echo "Surge: TVS clamp voltage:" $&v_surge_clamp "V"

  * Write results
  echo "RESULT:v_normal=$&v_normal" > simulation_results.txt
  echo "RESULT:v_reverse=$&v_reverse" >> simulation_results.txt
  echo "RESULT:v_surge_max=$&v_surge_max" >> simulation_results.txt

  * Checks:
  * 1. Normal output within 10% of input
  let normal_ok = (v_normal > 4.0)
  * 2. Reverse polarity output near 0
  let reverse_ok = (abs(v_reverse) < 0.5)
  * 3. Surge output clamped below 7V (TVS + margin)
  let surge_ok = (v_surge_max < 7.0)

  echo "Normal pass (>4V):" $&normal_ok
  echo "Reverse block (<0.5V):" $&reverse_ok
  echo "Surge clamp (<7V):" $&surge_ok

  if normal_ok and reverse_ok and surge_ok
    echo "PASS: Fault protection working correctly"
    echo "STATUS:PASS" >> simulation_results.txt
  else
    echo "FAIL: Fault protection issue detected"
    echo "STATUS:FAIL" >> simulation_results.txt
  end

  quit
.endc

.end
