* Overvoltage Protection — TVS Diode Clamp Test
*
* Normal: 5V supply → load sees ~4.5V
* Surge: 24V pulse → TVS clamps, load protected

.title Overvoltage Protection

* Input: 5V normal, 24V surge at t=10us
Vin vin 0 PULSE(5 24 10u 100n 100n 10u 50u)

* TVS diode (5.6V breakdown)
D1 vin 0 TVS
.model TVS D (BV=5.6 IBV=1 RS=0.5 CJO=200p)

* Series resistor + load
Rs vin vout 10
Rload vout 0 100

.tran 0.1u 40u

.control
  run

  meas tran vnorm avg v(vout) from=0 to=9u
  meas tran vsurge max v(vout) from=10u to=25u

  echo "=== Overvoltage Protection Results ==="
  echo "Normal Vout:" $&vnorm "V"
  echo "Surge max Vout:" $&vsurge "V"

  echo "RESULT:v_normal=$&vnorm" > simulation_results.txt
  echo "RESULT:v_surge_max=$&vsurge" >> simulation_results.txt

  let pass = 1
  if vnorm < 3.0
    let pass = 0
  end
  * TVS clamp + resistor divider should keep output reasonable
  if vsurge > 25
    let pass = 0
  end

  if pass
    echo "PASS: Overvoltage protection OK"
    echo "STATUS:PASS" >> simulation_results.txt
  else
    echo "FAIL: Protection issue"
    echo "STATUS:FAIL" >> simulation_results.txt
  end

  quit
.endc

.end
