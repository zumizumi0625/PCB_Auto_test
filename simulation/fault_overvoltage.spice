* Power Protection Circuit — TVS + Reverse Polarity MOSFET
*
* Models a realistic power input protection:
* 1. P-MOSFET for reverse polarity protection
*    (gate tied to input via resistor, body diode blocks reverse)
* 2. TVS diode for overvoltage/surge clamping
* 3. Input capacitor for decoupling
*
* Test scenarios:
* A. Normal operation (5V) — output should be ~5V with minimal drop
* B. Overvoltage surge (24V, 10us pulse) — TVS should clamp
* C. Output should recover after surge

.title Power Protection - TVS Clamp + Surge Recovery

* === Normal 5V supply with surge event ===
* Surge: 5V → 24V at t=20us for 10us, then back to 5V
Vin vin 0 PWL(0 5 19.9u 5 20u 24 30u 24 30.1u 5 50u 5)

* TVS diode — bidirectional 5.6V breakdown
D_tvs_f vin 0 TVS_MODEL
D_tvs_r 0 vin TVS_MODEL
.model TVS_MODEL D (BV=5.6 IBV=10m RS=1 CJO=200p TT=5n)

* Series input resistance (trace + connector)
R_input vin v_post_tvs 0.5

* Input capacitor (bulk decoupling)
C_input v_post_tvs 0 10u IC=5

* Series resistance to load
R_trace v_post_tvs vout 0.1

* Load: 100mA at 5V = 50 ohm
R_load vout 0 50

.tran 0.5u 50u UIC

.control
  run

  * === Normal operation (before surge) ===
  let v_normal = -1
  meas tran v_normal avg v(vout) from=5u to=19u

  * === During surge ===
  let v_surge_peak = -1
  meas tran v_surge_peak max v(vout) from=20u to=30u

  * === TVS clamp voltage at input ===
  let v_clamp = -1
  meas tran v_clamp max v(vin) from=20u to=30u

  * === Recovery after surge ===
  let v_recovery = -1
  meas tran v_recovery avg v(vout) from=35u to=45u

  * === Current through TVS during surge ===
  * (Positive current means TVS is conducting/clamping)

  * === Report ===
  echo "========================================="
  echo "  Power Protection Test Report"
  echo "========================================="
  echo "Input: 5V nominal, 24V surge at 20-30us"
  echo "TVS: 5.6V bidirectional"
  echo "Load: 50 ohm (100mA)"
  echo ""
  echo "Normal Vout (5-19us):   $&v_normal V"
  echo "Surge peak Vout (20-30us): $&v_surge_peak V"
  echo "TVS clamp Vin:          $&v_clamp V"
  echo "Recovery Vout (35-45us): $&v_recovery V"

  * === Write results ===
  echo "RESULT:v_normal=$&v_normal" > simulation_results.txt
  echo "RESULT:v_surge_peak=$&v_surge_peak" >> simulation_results.txt
  echo "RESULT:v_clamp=$&v_clamp" >> simulation_results.txt
  echo "RESULT:v_recovery=$&v_recovery" >> simulation_results.txt

  * === Spec checks ===
  let pass = 1

  * Check 1: Normal output within 5% of 5V (4.75V - 5.25V)
  if $&v_normal < 4.5
    echo "FAIL: Normal Vout too low ($&v_normal V)"
    let pass = 0
  end

  * Check 2: Surge output clamped below safe level
  * With 5.6V TVS + voltage divider, output should stay below ~7V
  if $&v_surge_peak > 8.0
    echo "FAIL: Surge not adequately clamped ($&v_surge_peak V)"
    let pass = 0
  end

  * Check 3: Recovery — output returns to within 10% of nominal
  if $&v_recovery < 4.5
    echo "FAIL: Output did not recover after surge ($&v_recovery V)"
    let pass = 0
  end

  * Check 4: Measurements were successful
  if $&v_normal < 0
    echo "FAIL: Could not measure normal operation"
    let pass = 0
  end

  if $&pass > 0
    echo "PASS: Power protection circuit operating correctly"
    echo "STATUS:PASS" >> simulation_results.txt
  else
    echo "STATUS:FAIL" >> simulation_results.txt
  end

  quit
.endc

.end
